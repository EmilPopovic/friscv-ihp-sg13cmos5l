* CDL Netlist generated by OpenROAD

*.BUSDELIMITER [

.SUBCKT delay_line_D4_O1_6P000 VDD VSS clk_i clk_o[0] delay_i[0]
+ delay_i[1] delay_i[2] delay_i[3]
XFILLER_0_0 VDD VSS sg13cmos5l_fill_8
XFILLER_0_21 VDD VSS sg13cmos5l_fill_1
XFILLER_0_31 VDD VSS sg13cmos5l_fill_4
XFILLER_0_35 VDD VSS sg13cmos5l_fill_2
XFILLER_0_46 VDD VSS sg13cmos5l_fill_8
XFILLER_0_54 VDD VSS sg13cmos5l_fill_2
XFILLER_0_65 VDD VSS sg13cmos5l_fill_8
XFILLER_0_73 VDD VSS sg13cmos5l_fill_8
XFILLER_0_8 VDD VSS sg13cmos5l_fill_4
XFILLER_0_81 VDD VSS sg13cmos5l_fill_4
XFILLER_0_85 VDD VSS sg13cmos5l_fill_2
XFILLER_0_87 VDD VSS sg13cmos5l_fill_1
XFILLER_10_0 VDD VSS sg13cmos5l_fill_8
XFILLER_10_46 VDD VSS sg13cmos5l_fill_2
XFILLER_10_57 VDD VSS sg13cmos5l_fill_2
XFILLER_10_68 VDD VSS sg13cmos5l_fill_4
XFILLER_10_72 VDD VSS sg13cmos5l_fill_1
XFILLER_10_8 VDD VSS sg13cmos5l_fill_2
XFILLER_10_82 VDD VSS sg13cmos5l_fill_4
XFILLER_10_86 VDD VSS sg13cmos5l_fill_2
XFILLER_11_0 VDD VSS sg13cmos5l_fill_2
XFILLER_11_27 VDD VSS sg13cmos5l_fill_4
XFILLER_11_40 VDD VSS sg13cmos5l_fill_8
XFILLER_11_48 VDD VSS sg13cmos5l_fill_8
XFILLER_11_56 VDD VSS sg13cmos5l_fill_2
XFILLER_11_67 VDD VSS sg13cmos5l_fill_8
XFILLER_11_75 VDD VSS sg13cmos5l_fill_8
XFILLER_11_83 VDD VSS sg13cmos5l_fill_4
XFILLER_11_87 VDD VSS sg13cmos5l_fill_1
XFILLER_1_0 VDD VSS sg13cmos5l_fill_4
XFILLER_1_33 VDD VSS sg13cmos5l_fill_4
XFILLER_1_37 VDD VSS sg13cmos5l_fill_1
XFILLER_1_4 VDD VSS sg13cmos5l_fill_2
XFILLER_1_56 VDD VSS sg13cmos5l_fill_4
XFILLER_1_60 VDD VSS sg13cmos5l_fill_2
XFILLER_1_80 VDD VSS sg13cmos5l_fill_8
XFILLER_2_0 VDD VSS sg13cmos5l_fill_4
XFILLER_2_35 VDD VSS sg13cmos5l_fill_4
XFILLER_2_39 VDD VSS sg13cmos5l_fill_1
XFILLER_2_4 VDD VSS sg13cmos5l_fill_2
XFILLER_2_50 VDD VSS sg13cmos5l_fill_2
XFILLER_2_6 VDD VSS sg13cmos5l_fill_1
XFILLER_2_61 VDD VSS sg13cmos5l_fill_4
XFILLER_2_84 VDD VSS sg13cmos5l_fill_4
XFILLER_3_18 VDD VSS sg13cmos5l_fill_1
XFILLER_3_28 VDD VSS sg13cmos5l_fill_2
XFILLER_3_30 VDD VSS sg13cmos5l_fill_1
XFILLER_3_49 VDD VSS sg13cmos5l_fill_8
XFILLER_3_57 VDD VSS sg13cmos5l_fill_8
XFILLER_3_83 VDD VSS sg13cmos5l_fill_4
XFILLER_3_87 VDD VSS sg13cmos5l_fill_1
XFILLER_4_0 VDD VSS sg13cmos5l_fill_4
XFILLER_4_22 VDD VSS sg13cmos5l_fill_1
XFILLER_4_33 VDD VSS sg13cmos5l_fill_1
XFILLER_4_4 VDD VSS sg13cmos5l_fill_1
XFILLER_4_62 VDD VSS sg13cmos5l_fill_4
XFILLER_4_66 VDD VSS sg13cmos5l_fill_1
XFILLER_4_87 VDD VSS sg13cmos5l_fill_1
XFILLER_5_0 VDD VSS sg13cmos5l_fill_2
XFILLER_5_2 VDD VSS sg13cmos5l_fill_1
XFILLER_5_30 VDD VSS sg13cmos5l_fill_1
XFILLER_5_49 VDD VSS sg13cmos5l_fill_8
XFILLER_5_57 VDD VSS sg13cmos5l_fill_2
XFILLER_5_82 VDD VSS sg13cmos5l_fill_4
XFILLER_5_86 VDD VSS sg13cmos5l_fill_2
XFILLER_6_0 VDD VSS sg13cmos5l_fill_4
XFILLER_6_14 VDD VSS sg13cmos5l_fill_2
XFILLER_6_4 VDD VSS sg13cmos5l_fill_2
XFILLER_6_62 VDD VSS sg13cmos5l_fill_4
XFILLER_6_66 VDD VSS sg13cmos5l_fill_2
XFILLER_6_87 VDD VSS sg13cmos5l_fill_1
XFILLER_7_0 VDD VSS sg13cmos5l_fill_8
XFILLER_7_12 VDD VSS sg13cmos5l_fill_1
XFILLER_7_23 VDD VSS sg13cmos5l_fill_4
XFILLER_7_37 VDD VSS sg13cmos5l_fill_8
XFILLER_7_45 VDD VSS sg13cmos5l_fill_8
XFILLER_7_53 VDD VSS sg13cmos5l_fill_8
XFILLER_7_61 VDD VSS sg13cmos5l_fill_8
XFILLER_7_69 VDD VSS sg13cmos5l_fill_1
XFILLER_7_8 VDD VSS sg13cmos5l_fill_4
XFILLER_8_0 VDD VSS sg13cmos5l_fill_8
XFILLER_8_46 VDD VSS sg13cmos5l_fill_4
XFILLER_8_50 VDD VSS sg13cmos5l_fill_2
XFILLER_8_52 VDD VSS sg13cmos5l_fill_1
XFILLER_8_62 VDD VSS sg13cmos5l_fill_8
XFILLER_8_70 VDD VSS sg13cmos5l_fill_2
XFILLER_8_72 VDD VSS sg13cmos5l_fill_1
XFILLER_8_8 VDD VSS sg13cmos5l_fill_4
XFILLER_8_82 VDD VSS sg13cmos5l_fill_4
XFILLER_8_86 VDD VSS sg13cmos5l_fill_2
XFILLER_9_0 VDD VSS sg13cmos5l_fill_4
XFILLER_9_29 VDD VSS sg13cmos5l_fill_4
XFILLER_9_37 VDD VSS sg13cmos5l_fill_2
XFILLER_9_57 VDD VSS sg13cmos5l_fill_4
XFILLER_9_61 VDD VSS sg13cmos5l_fill_1
XFILLER_9_81 VDD VSS sg13cmos5l_fill_4
XFILLER_9_85 VDD VSS sg13cmos5l_fill_2
XFILLER_9_87 VDD VSS sg13cmos5l_fill_1
Xhold1 net1 net46 VDD VSS sg13cmos5l_dlygate4sd2_1
Xhold10 net10 net11 VDD VSS sg13cmos5l_dlygate4sd3_1
Xhold11 net11 net43 VDD VSS sg13cmos5l_dlygate4sd3_1
Xhold12 net12 net13 VDD VSS sg13cmos5l_dlygate4sd3_1
Xhold13 net13 net15 VDD VSS sg13cmos5l_dlygate4sd3_1
Xhold14 net14 net12 VDD VSS sg13cmos5l_dlygate4sd3_1
Xhold15 net15 net43 VDD VSS sg13cmos5l_dlygate4sd2_1
Xhold16 net16 net18 VDD VSS sg13cmos5l_dlygate4sd3_1
Xhold17 net17 net20 VDD VSS sg13cmos5l_dlygate4sd3_1
Xhold18 net18 net21 VDD VSS sg13cmos5l_dlygate4sd3_1
Xhold19 net19 net16 VDD VSS sg13cmos5l_dlygate4sd3_1
Xhold20 net20 clk_l3m3o0 VDD VSS sg13cmos5l_dlygate4sd3_1
Xhold21 net21 net48 VDD VSS sg13cmos5l_dlygate4sd2_1
Xhold22 net22 net23 VDD VSS sg13cmos5l_dlygate4sd3_1
Xhold23 net23 net25 VDD VSS sg13cmos5l_dlygate4sd3_1
Xhold24 net24 net22 VDD VSS sg13cmos5l_dlygate4sd3_1
Xhold25 net25 net43 VDD VSS sg13cmos5l_dlygate4sd3_1
Xhold26 net26 clk_l3m7o0 VDD VSS sg13cmos5l_dlygate4sd3_1
Xhold27 net27 net74 VDD VSS sg13cmos5l_dlygate4sd3_1
Xhold28 net28 net32 VDD VSS sg13cmos5l_dlygate4sd3_1
Xhold29 net29 net34 VDD VSS sg13cmos5l_dlygate4sd3_1
Xhold3 net3 net46 VDD VSS sg13cmos5l_dlygate4sd3_1
Xhold30 net30 net37 VDD VSS sg13cmos5l_dlygate4sd3_1
Xhold31 net31 clk_l2m3o0 VDD VSS sg13cmos5l_dlygate4sd3_1
Xhold32 net32 clk_l3m4o0 VDD VSS sg13cmos5l_dlygate4sd3_1
Xhold33 net33 net28 VDD VSS sg13cmos5l_dlygate4sd3_1
Xhold34 net34 clk_l2m2o0 VDD VSS sg13cmos5l_dlygate4sd3_1
Xhold36 net36 net54 VDD VSS sg13cmos5l_dlygate4sd3_1
Xhold37 net37 clk_l1m1o0 VDD VSS sg13cmos5l_dlygate4sd3_1
Xhold39 net39 net45 VDD VSS sg13cmos5l_dlygate4sd3_1
Xhold4 net4 net5 VDD VSS sg13cmos5l_dlygate4sd3_1
Xhold40 clk_o[0] net40 VDD VSS sg13cmos5l_buf_8
Xhold41 net41 net44 VDD VSS sg13cmos5l_dlygate4sd3_1
Xhold42 net42 net39 VDD VSS sg13cmos5l_dlygate4sd3_1
Xhold44 net44 clk_l3m5o0 VDD VSS sg13cmos5l_dlygate4sd3_1
Xhold45 net45 net41 VDD VSS sg13cmos5l_dlygate4sd3_1
Xhold46 net51 clk_i VDD VSS sg13cmos5l_buf_16
Xhold49 net49 net58 VDD VSS sg13cmos5l_dlygate4sd3_1
Xhold5 net5 net6 VDD VSS sg13cmos5l_dlygate4sd3_1
Xhold50 net50 net36 VDD VSS sg13cmos5l_dlygate4sd3_1
Xhold52 net52 net57 VDD VSS sg13cmos5l_dlygate4sd3_1
Xhold54 net54 net31 VDD VSS sg13cmos5l_dlygate4sd3_1
Xhold55 net55 net50 VDD VSS sg13cmos5l_dlygate4sd3_1
Xhold57 net57 clk_l3m6o0 VDD VSS sg13cmos5l_dlygate4sd3_1
Xhold58 net58 net52 VDD VSS sg13cmos5l_dlygate4sd3_1
Xhold6 net6 net46 VDD VSS sg13cmos5l_dlygate4sd2_1
Xhold66 net66 net75 VDD VSS sg13cmos5l_dlygate4sd3_1
Xhold69 net69 net27 VDD VSS sg13cmos5l_dlygate4sd3_1
Xhold7 net7 net10 VDD VSS sg13cmos5l_dlygate4sd3_1
Xhold70 net70 net66 VDD VSS sg13cmos5l_dlygate4sd3_1
Xhold74 net74 net26 VDD VSS sg13cmos5l_dlygate4sd3_1
Xhold75 net75 net69 VDD VSS sg13cmos5l_dlygate4sd3_1
Xi_mx_l0m0o0 net40 clk_l1m0o0 net30 delay_i[0] VDD VSS sg13cmos5l_mux2_2
Xi_mx_l1m0o0 clk_l1m0o0 clk_l2m0o0 clk_l2m1o0 delay_i[1] VDD
+ VSS sg13cmos5l_mux2_1
Xi_mx_l1m1o0 clk_l1m1o0 net29 net55 delay_i[1] VDD VSS sg13cmos5l_mux2_1
Xi_mx_l2m0o0 clk_l2m0o0 clk_l3m0o0 clk_l3m1o0 delay_i[2] VDD
+ VSS sg13cmos5l_mux2_1
Xi_mx_l2m1o0 clk_l2m1o0 clk_l3m2o0 net17 delay_i[2] VDD VSS
+ sg13cmos5l_mux2_1
Xi_mx_l2m2o0 clk_l2m2o0 net33 net42 delay_i[2] VDD VSS sg13cmos5l_mux2_1
Xi_mx_l2m3o0 clk_l2m3o0 net49 net70 delay_i[2] VDD VSS sg13cmos5l_mux2_1
Xi_mx_l3m0o0 clk_l3m0o0 net46 net1 delay_i[3] VDD VSS sg13cmos5l_mux2_1
Xi_mx_l3m1o0 clk_l3m1o0 net3 net4 delay_i[3] VDD VSS sg13cmos5l_mux2_1
Xi_mx_l3m2o0 clk_l3m2o0 net7 net14 delay_i[3] VDD VSS sg13cmos5l_mux2_1
Xi_mx_l3m3o0 clk_l3m3o0 net19 net24 delay_i[3] VDD VSS sg13cmos5l_mux2_1
Xi_mx_l3m4o0 clk_l3m4o0 net43 net43 delay_i[3] VDD VSS sg13cmos5l_mux2_1
Xi_mx_l3m5o0 clk_l3m5o0 net43 net43 delay_i[3] VDD VSS sg13cmos5l_mux2_1
Xi_mx_l3m6o0 clk_l3m6o0 net53 net53 delay_i[3] VDD VSS sg13cmos5l_mux2_1
Xi_mx_l3m7o0 clk_l3m7o0 net51 net47 delay_i[3] VDD VSS sg13cmos5l_mux2_1
Xrebuffer41 net43 net48 VDD VSS sg13cmos5l_buf_8
Xrebuffer42 net46 net47 VDD VSS sg13cmos5l_buf_16
Xrebuffer43 net47 net51 VDD VSS sg13cmos5l_buf_16
Xrebuffer44 net48 net46 VDD VSS sg13cmos5l_buf_1
Xrebuffer47 net53 net46 VDD VSS sg13cmos5l_buf_1
.ENDS delay_line_D4_O1_6P000
